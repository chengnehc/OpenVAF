module test;
    parameter real p = inf;
    real x;

    analog x = -inf;
endmodule
