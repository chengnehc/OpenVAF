module test1;
    parameter real foo=1;
    real v;

    analog begin
        begin
            parameter bar=1;
            real v;
        end

        begin : myscope
            v = $mfactor * foo;
            parameter qux=1;
        end
    end
endmodule
