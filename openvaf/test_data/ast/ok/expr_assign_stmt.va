module test;
    electrical a;
    real foo = 3.14;
    analog begin
        // expression statement
        baz;
        exp(baz);
        // assignment statement
        foo = 3.1415;
        V(a) <+ 1m * foo;
    end
endmodule
