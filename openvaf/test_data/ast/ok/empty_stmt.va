module test;
    analog ;
    analog begin
        ;;
    end
endmodule
