module test ();
    real x=1.0;
    integer y=0,z;
    real t;
    string s;
    int rt;  // this is problematic
    analog x = 2==y;
endmodule
