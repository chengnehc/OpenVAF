module test;
    integer foo, baz
    real qux;
endmodule
