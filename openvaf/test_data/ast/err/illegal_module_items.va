// TODO(JW): should err
module test;
    foo baz;
endmodule
