module foo;
endmodule

module bar (a,b,c,d,e,f,g);
    output a;
    input b;
    inout ground c;
    inout electrical d;
    output electrical e,f;
    inout electrical ground g;
endmodule

module zaf (output a,b, input electrical c,d,e, (*foo*) inout electrical ground f);
endmodule
