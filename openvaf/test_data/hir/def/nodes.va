module test(foo, test);
    electrical foo;
    inout foo;
    electrical bar;
    ground bar;
    inout electrical test;
endmodule
