module test;
    parameter real p_module = 0;
    real v_module;

    analog function real maxValue;
        input n1, n2;
        real n1, n2;
        parameter real p_local = 0;
        real v_local;
        begin
            // OK: analog functions can reference locally-defined paramters and variables
            v_local = p_local;
            // OK: analog functions can reference module-level parameters.
            v_local = p_module > 0 ? 0 : 1;

            // Err: analog functions can not access non-local variables
            foo = p_local;

            maxValue = (n1 > n2) ? n1 : n2;
        end
    endfunction
endmodule
