nature Current: electrical.flow;
endnature
