// argument variable binding
module test1;
    analog function real bar;
        input a;
        real a, b;

        // duplicate function argument binding
        real a;
        // unbinded function argument
        input c;

        begin
            ;
        end
    endfunction
endmodule

// write to input argument
module test2;
    analog function real geomcalc;
        input l, w;
        input area, perim;
        real l, w, area, perim;
        begin
            area = l * w;
            perim = 2 * ( l + w );
        end
    endfunction
endmodule
