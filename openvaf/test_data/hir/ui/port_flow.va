`include "disciplines.vams"

// port 'a' is not declared with direction
// illegal potential access of port flow branch
module test1(a);
    electrical a;
    branch(<a>) port_flow;

    analog begin
        I(a) <+ V(port_flow);
    end
endmodule

// 'b' is not declared as port
module test2(a);
    inout electrical a;
    electrical b;
    branch(<b>) port_flow;
endmodule
