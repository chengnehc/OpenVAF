module test;
    analog function real foo;
        input a, b;
        real a;

        begin
            ;
        end
    endfunction

    analog function real bar;
        input a;
        real a, b;

        // duplicate function argument binding
        real a;
        // unbinded function argument
        input c;

        begin
            ;
        end
    endfunction
endmodule
