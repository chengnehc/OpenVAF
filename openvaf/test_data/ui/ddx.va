`include "disciplines.va"

(* openvaf_allow="trivial_probe" *)
module diode(a, c);
    inout a, c;
    electrical a, c;
    branch (a,c) br_ac;
    real x, foo;

    analog begin
        // OK
        x = ddx(1.0,V(a));
        x = ddx(1.0,I(br_ac));
        x = ddx(1.0,I(a,c));
        // OK but non-standard
        x = ddx(1.0,V(a,c));
        x = ddx(1.0,$temperature);

        // these must be rejected
        x = ddx(1.0,V(br_ac));
        x = ddx(1.0,I(a));
        x = ddx(1.0,I(<a>));
        x = ddx(1.0,V(<a>));
        // random fuzz
        x = ddx(1.0,1.0);
        x = ddx(1.0,foo);
    end
endmodule
